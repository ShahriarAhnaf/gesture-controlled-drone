* PalmPilot flex_refinement; extracted passive topology, explicit approximations
Vevent evt 0 PWL(0 0 5m 0 5.000001m 1 45m 1 45.000001m 2)
V0 v0 0 3.3
B0 v0 a0 I=V(v0,a0)/(V(evt)<.5 ? 25000 : (V(evt)<1.5 ? 100000 : 1e12))
R0 a0 0 47000.0
C0 a0 0 1e-07
I0 0 a0 0.0
V1 v1 0 3.135
B1 v1 a1 I=V(v1,a1)/(V(evt)<.5 ? 25000 : (V(evt)<1.5 ? 100000 : 1e12))
R1 a1 0 46530.0
C1 a1 0 8e-08
I1 0 a1 -5e-08
V2 v2 0 3.135
B2 v2 a2 I=V(v2,a2)/(V(evt)<.5 ? 25000 : (V(evt)<1.5 ? 100000 : 1e12))
R2 a2 0 46530.0
C2 a2 0 8e-08
I2 0 a2 5e-08
V3 v3 0 3.135
B3 v3 a3 I=V(v3,a3)/(V(evt)<.5 ? 25000 : (V(evt)<1.5 ? 100000 : 1e12))
R3 a3 0 46530.0
C3 a3 0 1.2e-07
I3 0 a3 -5e-08
V4 v4 0 3.135
B4 v4 a4 I=V(v4,a4)/(V(evt)<.5 ? 25000 : (V(evt)<1.5 ? 100000 : 1e12))
R4 a4 0 46530.0
C4 a4 0 1.2e-07
I4 0 a4 5e-08
V5 v5 0 3.135
B5 v5 a5 I=V(v5,a5)/(V(evt)<.5 ? 25000 : (V(evt)<1.5 ? 100000 : 1e12))
R5 a5 0 47470.0
C5 a5 0 8e-08
I5 0 a5 -5e-08
V6 v6 0 3.135
B6 v6 a6 I=V(v6,a6)/(V(evt)<.5 ? 25000 : (V(evt)<1.5 ? 100000 : 1e12))
R6 a6 0 47470.0
C6 a6 0 8e-08
I6 0 a6 5e-08
V7 v7 0 3.135
B7 v7 a7 I=V(v7,a7)/(V(evt)<.5 ? 25000 : (V(evt)<1.5 ? 100000 : 1e12))
R7 a7 0 47470.0
C7 a7 0 1.2e-07
I7 0 a7 -5e-08
V8 v8 0 3.135
B8 v8 a8 I=V(v8,a8)/(V(evt)<.5 ? 25000 : (V(evt)<1.5 ? 100000 : 1e12))
R8 a8 0 47470.0
C8 a8 0 1.2e-07
I8 0 a8 5e-08
V9 v9 0 3.465
B9 v9 a9 I=V(v9,a9)/(V(evt)<.5 ? 25000 : (V(evt)<1.5 ? 100000 : 1e12))
R9 a9 0 46530.0
C9 a9 0 8e-08
I9 0 a9 -5e-08
V10 v10 0 3.465
B10 v10 a10 I=V(v10,a10)/(V(evt)<.5 ? 25000 : (V(evt)<1.5 ? 100000 : 1e12))
R10 a10 0 46530.0
C10 a10 0 8e-08
I10 0 a10 5e-08
V11 v11 0 3.465
B11 v11 a11 I=V(v11,a11)/(V(evt)<.5 ? 25000 : (V(evt)<1.5 ? 100000 : 1e12))
R11 a11 0 46530.0
C11 a11 0 1.2e-07
I11 0 a11 -5e-08
V12 v12 0 3.465
B12 v12 a12 I=V(v12,a12)/(V(evt)<.5 ? 25000 : (V(evt)<1.5 ? 100000 : 1e12))
R12 a12 0 46530.0
C12 a12 0 1.2e-07
I12 0 a12 5e-08
V13 v13 0 3.465
B13 v13 a13 I=V(v13,a13)/(V(evt)<.5 ? 25000 : (V(evt)<1.5 ? 100000 : 1e12))
R13 a13 0 47470.0
C13 a13 0 8e-08
I13 0 a13 -5e-08
V14 v14 0 3.465
B14 v14 a14 I=V(v14,a14)/(V(evt)<.5 ? 25000 : (V(evt)<1.5 ? 100000 : 1e12))
R14 a14 0 47470.0
C14 a14 0 8e-08
I14 0 a14 5e-08
V15 v15 0 3.465
B15 v15 a15 I=V(v15,a15)/(V(evt)<.5 ? 25000 : (V(evt)<1.5 ? 100000 : 1e12))
R15 a15 0 47470.0
C15 a15 0 1.2e-07
I15 0 a15 -5e-08
V16 v16 0 3.465
B16 v16 a16 I=V(v16,a16)/(V(evt)<.5 ? 25000 : (V(evt)<1.5 ? 100000 : 1e12))
R16 a16 0 47470.0
C16 a16 0 1.2e-07
I16 0 a16 5e-08
V17 v17 0 3.3
B17 v17 a17 I=V(v17,a17)/(V(evt)<.5 ? 25000 : (V(evt)<1.5 ? 100000 : 1e12))
R17 a17 0 47000
C17 a17 0 1e-07
I17 0 a17 1e-06
V18 v18 0 3.3
B18 v18 a18 I=V(v18,a18)/(V(evt)<.5 ? 25000 : (V(evt)<1.5 ? 100000 : 1e12))
R18 a18 0 47000
C18 a18 0 1e-07
I18 0 a18 -1e-06

.options reltol=1e-6 abstol=1e-12 vntol=1e-8
.control
set wr_singlescale
set wr_vecnames
tran 5u 120m 0 5u
wrdata /Users/anoof/Documents/Codex/2026-11-17/https-github-com-samiurr10-gesture-controlled-2/work/gesture-controlled-drone/hardware/simulation/results/flex_refinement.dat v(a0) v(a1) v(a2) v(a3) v(a4) v(a5) v(a6) v(a7) v(a8) v(a9) v(a10) v(a11) v(a12) v(a13) v(a14) v(a15) v(a16) v(a17) v(a18)
quit
.endc
.end
