* PalmPilot hard_short_and_open; extracted passive topology, explicit approximations
Vrail vdd 0 3.3
Vevent evt 0 PWL(0 0 5m 0 5.000001m 1 45m 1 45.000001m 2)
Bflex vdd adc I=V(vdd,adc)/(V(evt)<.5 ? 25000 : (V(evt)<1.5 ? .5 : 1e12))
Rshunt adc 0 47470
Cshunt adc 0 120n

.options reltol=1e-6 abstol=1e-12 vntol=1e-8
.control
set wr_singlescale
set wr_vecnames
tran 2u 110m 0 2u
wrdata /Users/anoof/Documents/Codex/2026-11-17/https-github-com-samiurr10-gesture-controlled-2/work/gesture-controlled-drone/hardware/simulation/results/hard_short_and_open.dat v(adc)
quit
.endc
.end
