* PalmPilot adc_charge_sensitivity; extracted passive topology, explicit approximations
VDD vdd 0 3.3
Rflex vdd adc 100k
Rshunt adc 0 47k
Cshunt adc 0 80n
Ikick adc 0 PULSE(0 6.2m 1m .01n .01n 10n 10m)

.options reltol=1e-6 abstol=1e-12 vntol=1e-8
.control
set wr_singlescale
set wr_vecnames
tran 1u 4m 0 1u
wrdata /Users/anoof/Documents/Codex/2026-11-17/https-github-com-samiurr10-gesture-controlled-2/work/gesture-controlled-drone/hardware/simulation/results/adc_charge_sensitivity.dat v(adc)
quit
.endc
.end
