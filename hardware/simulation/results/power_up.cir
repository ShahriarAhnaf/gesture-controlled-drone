* PalmPilot power_up; extracted passive topology, explicit approximations
Vrail vdd 0 PWL(0 0 1m 0 2m 3.3)
Rflex vdd adc 100k
Rshunt adc 0 47470
Cshunt adc 0 120n

.options reltol=1e-6 abstol=1e-12 vntol=1e-8
.control
set wr_singlescale
set wr_vecnames
tran 2u 70m 0 2u
wrdata /Users/anoof/Documents/Codex/2026-11-17/https-github-com-samiurr10-gesture-controlled-2/work/gesture-controlled-drone/hardware/simulation/results/power_up.dat v(adc)
quit
.endc
.end
