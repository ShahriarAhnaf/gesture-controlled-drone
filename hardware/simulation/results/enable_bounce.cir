* PalmPilot enable_bounce; extracted passive topology, explicit approximations
VDD vdd 0 3.3
Rpull vdd en 10k
Cdeb en 0 100n
Rseries en sw 1k
Sbutton sw 0 ctl 0 BTN
.model BTN SW(Ron=1 Roff=1e12 Vt=.5 Vh=.05)
VC ctl 0 PWL(0 0 10m 0 10.001m 1 10.3m 1 10.301m 0 10.6m 0 10.601m 1 10.9m 1 10.901m 0 11.2m 0 11.201m 1 11.6m 1 11.601m 0 12m 0 12.001m 1 50m 1 50.001m 0 50.3m 0 50.301m 1 50.6m 1 50.601m 0 50.9m 0 50.901m 1 51.2m 1 51.201m 0)

.options reltol=1e-6 abstol=1e-12 vntol=1e-8
.control
set wr_singlescale
set wr_vecnames
tran 1u 80m 0 1u
wrdata /Users/anoof/Documents/Codex/2026-11-17/https-github-com-samiurr10-gesture-controlled-2/work/gesture-controlled-drone/hardware/simulation/results/enable_bounce.dat v(en) v(ctl)
quit
.endc
.end
